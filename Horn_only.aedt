# Ansys Electronics Desktop project, version 2021.2
materials:
  vacuum: permittivity=1
  pec: conductivity=1e+30

design Horn2D (HFSS, DrivenModal, model units mm)
geometry:
  Axis_1, HornWallClosed_2, InnerBottom_4, OuterBottom_6 = imported_body(C:/Users/mnwider/Documents/Ansoft/temp/38F03185617570812267..sm3)
  HornWallClosed_2_ObjectFromFace1 [pec] = object_from(?.face(#2097))
  HornWallClosed_2_ObjectFromFace1.sweep_around_axis(axis=X, angle=360deg)
  Circle1 = circle(normal=X, centre=(0mm, 0mm, 0.1mm), radius=15.811388mm)
