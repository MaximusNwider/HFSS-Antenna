# Ansys Electronics Desktop project, version 2021.2
materials:
  vacuum: permittivity=1
  pec: conductivity=1e+30
  aluminum: permeability=1.000021 conductivity=38000000
  PMLGroup1_Z_1: permittivity{anisotropic component1=1.1 component2=1.1 component3=0.45454545} permeability{anisotropic component1=1.1 component2=1.1 component3=0.45454545} dielectric_loss_tangent{anisotropic component1=1 component2=1 component3=-1} magnetic_loss_tangent{anisotropic component1=1 component2=1 component3=-1}
  PMLGroup1_XZ_1: permittivity{anisotropic component1=1 component2=0.01 component3=1} permeability{anisotropic component1=1 component2=0.01 component3=1} dielectric_loss_tangent{anisotropic component1=0 component2=242 component3=0} magnetic_loss_tangent{anisotropic component1=0 component2=242 component3=0}
  PMLGroup1_YZ_1: permittivity{anisotropic component1=0.01 component2=1 component3=1} permeability{anisotropic component1=0.01 component2=1 component3=1} dielectric_loss_tangent{anisotropic component1=242 component2=0 component3=0} magnetic_loss_tangent{anisotropic component1=242 component2=0 component3=0}
  PMLGroup1_XYZ_1: permittivity{anisotropic component1=1.1 component2=1.1 component3=1.1} permeability{anisotropic component1=1.1 component2=1.1 component3=1.1} dielectric_loss_tangent{anisotropic component1=1 component2=1 component3=1} magnetic_loss_tangent{anisotropic component1=1 component2=1 component3=1}
  PMLGroup2_Z_1: permittivity{anisotropic component1=30.358783 component2=30.358783 component3=0.016469698} permeability{anisotropic component1=30.358783 component2=30.358783 component3=0.016469698} dielectric_loss_tangent{anisotropic component1=1 component2=1 component3=-1} magnetic_loss_tangent{anisotropic component1=1 component2=1 component3=-1}
  PMLGroup3_Z_1: permittivity{anisotropic component1=30.358783 component2=30.358783 component3=0.016469698} permeability{anisotropic component1=30.358783 component2=30.358783 component3=0.016469698} dielectric_loss_tangent{anisotropic component1=1 component2=1 component3=-1} magnetic_loss_tangent{anisotropic component1=1 component2=1 component3=-1}
  PMLGroup4_Z_1: permittivity{anisotropic component1=1.1 component2=1.1 component3=0.45454545} permeability{anisotropic component1=1.1 component2=1.1 component3=0.45454545} dielectric_loss_tangent{anisotropic component1=1 component2=1 component3=-1} magnetic_loss_tangent{anisotropic component1=1 component2=1 component3=-1}
  PMLGroup4_XZ_1: permittivity{anisotropic component1=1 component2=0.01 component3=1} permeability{anisotropic component1=1 component2=0.01 component3=1} dielectric_loss_tangent{anisotropic component1=0 component2=242 component3=0} magnetic_loss_tangent{anisotropic component1=0 component2=242 component3=0}
  PMLGroup4_YZ_1: permittivity{anisotropic component1=0.01 component2=1 component3=1} permeability{anisotropic component1=0.01 component2=1 component3=1} dielectric_loss_tangent{anisotropic component1=242 component2=0 component3=0} magnetic_loss_tangent{anisotropic component1=242 component2=0 component3=0}
  PMLGroup4_XYZ_1: permittivity{anisotropic component1=1.1 component2=1.1 component3=1.1} permeability{anisotropic component1=1.1 component2=1.1 component3=1.1} dielectric_loss_tangent{anisotropic component1=1 component2=1 component3=1} magnetic_loss_tangent{anisotropic component1=1 component2=1 component3=1}

design HFSSDesign1 (HFSS, DrivenModal, model units mm)
geometry:
  0_2 = imported_body(C:/Users/mnwider/Documents/Ansoft/temp/69817760175798037234..sm3)
  Cone [aluminum] = object_from(?.face(#220))
  0_2.delete()
  Cone.sweep_around_axis(axis=Z, angle=360deg)
  RadiatingSurface [vacuum] = region(+X=20mm absolute offset, -X=20mm absolute offset, +Y=20mm absolute offset, -Y=20mm absolute offset, +Z=20mm absolute offset, -Z=0mm absolute position)
  Circle1 = circle(normal=Z, centre=(0mm, 0mm, 0mm), radius=15.8mm)
  Circle1_ObjectFromFace1 = object_from(Circle1.face(at (0, 0, 0)))
boundaries and excitations:
  Open1: Radiation Objects=RadiatingSurface
  1: Wave Port Objects=Circle1_ObjectFromFace1 NumModes=1 Modes{Mode1{CharImp=Zpi}}
setups:
  Setup1: HfssDriven Frequency=5GHz MaxDeltaS=0.02 MaximumPasses=6 MinimumPasses=1 MinimumConvergedPasses=1 PercentRefinement=30 BasisOrder=1 PortAccuracy=2
    sweep Sweep: 5GHz to 10GHz, 401 points; Type=Interpolating SaveFields InterpTolerance=0.5 InterpMaxSolns=250 InterpUsePortImped=false PassivityErrorTolerance=0.0001
source amplitudes:
  1:1: 1W 0deg
radiation setups:
  3D: Infinite Sphere Theta=0deg..180deg step 2deg Phi=-180deg..180deg step 2deg
  Elevation: Infinite Sphere Theta=-180deg..180deg step 1deg Phi=0deg..90deg step 90deg
  Azimuth: Infinite Sphere Theta=90deg..90deg step 0deg Phi=-180deg..180deg step 1deg
reports:
  Gain Plot 1: dB(GainTotal) vs Phi, Theta on Setup1 : LastAdaptive, 3D [Freq=7.5GHz]
  Gain Plot 2: dB(GainTotal) vs Phi, Theta on Setup1 : LastAdaptive, 3D [Freq=5GHz]
